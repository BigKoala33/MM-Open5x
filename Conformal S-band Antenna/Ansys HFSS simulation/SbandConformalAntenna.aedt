# Ansys Electronics Desktop project, version 2025.2
project datasets:
  $ds1: units GHz, : (0, 2500) (1600000000, 2500) (2750000000, 2800) (3750000000, 3100) (5000000000, 3650) (30000000000, 3650)
  $ds2: units GHz, : (0, 0.007) (1000000000, 0.007) (2000000000, 0.01) (3000000000, 0.014) (4000000000, 0.018) (5000000000, 0.02) (30000000000, 0.02)
  $ds3: units GHz, : (0, 2500) (1600000000, 2500) (2750000000, 2800) (3750000000, 3100) (5000000000, 3650) (30000000000, 3650)
  $ds4: units GHz, : (100000000, 0.005) (1600000000, 0.01) (2750000000, 0.014) (3750000000, 0.017) (5000000000, 0.021) (30000000000, 0.023)
materials:
  vacuum: permittivity=1
  Electrifi: permeability=0.999991 conductivity=pwl($ds3,Freq) lande_g_factor=2
  copper: permeability=0.999991 conductivity=58000000
  PLA: permittivity=2.6 dielectric_loss_tangent=pwl($ds4,Freq)
  Teflon (tm): permittivity=2.1 dielectric_loss_tangent=0.001
  pec: conductivity=1e+30

design Simulation (HFSS, HFSS Terminal Network, model units mm)
options: open_region{BoundaryType=0 OpFreq=2.45GHz}
variables:
  Rh = 12mm
  L = 22.55mm  -thickness/2
  yf = 3.27mm
  S = 71.5mm
  Hs = 2mm
  W = 47mm
  thickness = 0.8mm
  Hb = Rh*(1-cos(asin(L/(2*Rh))))
  pol = -20mm
geometry:
  ConformalSubstrate [PLA] = circle(normal=Y, centre=(0mm, W/2, (Hb+hS)-Rh), radius=Rh-thickness, segments=100)
  Rect = rectangle(corner=(-S/2, -S/2, 0mm), x_size=S, y_size=S)
  Rect.sweep_along_vector((0mm, 0mm, hS))
  ConformalSubstrate.split(plane=Rectangle1_1.face(6 of 6), keep=NegativeOnly)
  Rectangle1_1 = Rect.copy()
  [Rect, Rectangle1_1].delete()
  ConformalSubstrate.sweep_along_vector((0mm, -W, 0mm))
  ConformalElectrifi [Electrifi] = circle(normal=Y, centre=(0mm, W/2, (Hb+hS)-Rh), radius=Rh, segments=100)
  ConformalElectrifi.split(plane=Rectangle1_2.face(6 of 6), keep=NegativeOnly)
  ConformalElectrifi.sweep_along_vector((0mm, -W, 0mm))
  Rectangle2 = rectangle(corner=(-S/2, -S/2, 0mm), x_size=S, y_size=S)
  Rectangle2.sweep_along_vector((0mm, 0mm, hS))
  Rectangle1_2 = Rectangle2.copy()
  [Rectangle2, Rectangle1_2].delete()
  Circle1_1 = ConformalSubstrate.copy()
  ConformalElectrifi.subtract(Circle1_1)
  PinUp = circle(normal=Z, centre=(L/2-yf, 0mm, 0mm), radius=1mm)
  PinUp.sweep_along_vector((0mm, 0mm, 10mm))
  PinDown [pec] = circle(normal=Z, centre=(L/2-yf, 0mm, 0mm), radius=1mm)
  PinDown.sweep_along_vector((0mm, 0mm, pol))
  TeflonSMA [Teflon (tm)] = circle(normal=Z, centre=(L/2-yf, 0mm, 0mm), radius=3.5mm)
  TeflonSMA.sweep_along_vector((0mm, 0mm, pol))
  Circle6 = circle(normal=Y, centre=(0mm, W/2, (Hb+Hs)-Rh), radius=Rh*3, segments=100)
  Circle6.split(plane=Rectangle1_3.face(6 of 6), keep=NegativeOnly)
  Circle6.sweep_along_vector((0mm, -W, 0mm))
  Rectangle4 = rectangle(corner=(-S/2, -S/2, 0mm), x_size=S, y_size=S)
  Rectangle4.sweep_along_vector((0mm, 0mm, hS))
  Rectangle1_3 = Rectangle4.copy()
  [Rectangle4, Rectangle1_3].delete()
  Circle1_2 = ConformalSubstrate.copy()
  Circle2_1 = ConformalElectrifi.copy()
  Circle6.subtract(Circle1_2, Circle2_1)
  PinUp.subtract(Circle6)
  PinTop [pec] = PinUp.copy()
  PinUp_2 = PinUp.copy()
  ConformalSubstrate.subtract(PinUp_2)
  PinDown_1 = PinDown.copy()
  TeflonSMA.subtract(PinDown_1)
  Port = circle(normal=Z, centre=(L/2-yf, 0mm, pol), radius=3.5mm)
  RadiatingSurface [vacuum] = region(absolute_offset=40.816327mm on all sides)
  CoaxShield [Teflon (tm)] = object_from(TeflonSMA.face(at (11.305, 0, -10)))
  pecCap1 [pec] = sweep_along_normal(Port.face(at (7.805, 0, -20)), length=-0.98mm)
  Substrate [PLA] = circle(normal=Z, centre=(0, 0, 0), radius=40mm)
  Substrate.sweep_along_vector((0mm, 0mm, hS))
  PinUp_4 = PinUp.copy()
  PinUp.delete()
  Substrate.subtract(PinUp_4)
  GroundPlane = circle(normal=Z, centre=(0mm, 0mm, 0mm), radius=40mm)
  PinDown_3 = PinDown.copy()
  TeflonSMA_2 = TeflonSMA.copy()
  GroundPlane.subtract(PinDown_3, TeflonSMA_2)
  point Point1 = (0mm, 23.5mm, -2.6199973mm)
  Polyline1 [non-model] = polyline((0mm, 23.5mm, -2.6199973mm) (-20mm, 23.5mm, -2.6199973mm))
  coordinate_system RelativeCS1 = origin=(0mm, 23.5mm, -2.6199973mm) x=(1mm, 0mm, 0mm) y=(0mm, 1mm, 0mm)
  Polyline1_1 = Polyline1.duplicate_around_axis(axis=Y, angle=29deg, total=2) in RelativeCS1
  Polyline2 = polyline((-17.492394mm, 0mm, 9.6961924mm) (-17.492394mm, 0mm, -3mm)) in RelativeCS1
  Polyline3 = polyline((-17.492394mm, 0mm, -3mm) (0mm, 0mm, -3mm)) in RelativeCS1
  Polyline2.unite(Polyline1_1, Polyline3)
  Polyline2_1 = Polyline2.duplicate_mirror(point=(0mm, 0mm, 0mm), normal=(-1mm, 0mm, 0mm)) in RelativeCS1
  Polyline2.unite(Polyline2_1)
  Polyline2.cover_lines()
  Polyline2.sweep_along_vector((0mm, -70mm, 0mm)) in RelativeCS1
  ConformalElectrifi.subtract(Polyline2)
  PinUp_1_1 = PinTop.copy()
  ConformalElectrifi.subtract(PinUp_1_1)
boundaries and excitations:
  AutoOpen1: Radiation Objects=RadiatingSurface
  CoaxShield: Perfect E Objects=CoaxShield
  GroundPlane: Perfect E Objects=GroundPlane
  PinDown_T1: Terminal port=1 Faces=PinDown.face(at (7.805, 0, -20)) TerminalResistance=50ohm
  1: Wave Port Faces=Port.face(at (7.805, 0, -20)) WavePortType=Terminal NumModes=1 SpecifiedWaveDirectionFlip
  reference conductors: CoaxShield
mesh:
  initial mesh: GlobalSurfApproximation{CurvedSurfaceApproxChoice=UseSlider SliderMeshSettings=2} GlobalCurvilinear{Apply} GlobalModelRes{DefeatureLength=0.02mm} DynamicSurfaceResolution
setups:
  Auto1: HfssDriven Frequency=2.45GHz MaxDeltaS=0.04 MaximumPasses=12 MinimumPasses=1 MinimumConvergedPasses=1 PercentRefinement=10 BasisOrder=1 PortAccuracy=2 DrivenSolverType="Direct Solver"
    sweep Sweep: 1GHz to 5GHz, 401 points; Type=Interpolating SaveFields InterpTolerance=0.5 InterpMaxSolns=250 PassivityErrorTolerance=0.0001
source amplitudes:
  1:1: 1V 0deg
radiation setups:
  3D: Infinite Sphere Theta=0deg..180deg step 2deg Phi=-180deg..180deg step 2deg
  Elevation: Infinite Sphere Theta=-180deg..180deg step 1deg Phi=0deg..90deg step 90deg
  Azimuth: Infinite Sphere Theta=90deg..90deg step 0deg Phi=-180deg..180deg step 1deg
reports:
  Terminal S Parameter Plot1: dB(St(PinDown_T1,PinDown_T1)) vs Freq on Auto1 : Sweep
