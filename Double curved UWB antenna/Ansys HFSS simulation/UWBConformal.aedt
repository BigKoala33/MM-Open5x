# Ansys Electronics Desktop project, version 2025.2
project datasets:
  $ds1: units GHz, : (100000000, 2500) (1600000000, 2500) (2750000000, 2800) (3750000000, 3100) (5000000000, 3650) (30000000000, 3650)
  $ds2: units GHz, : (100000000, 0.005) (1600000000, 0.01) (2750000000, 0.014) (3750000000, 0.017) (5000000000, 0.021) (30000000000, 0.023)
materials:
  vacuum: permittivity=1
  pec: conductivity=1e+30
  Rogers RT/duroid 5880 (tm): permittivity=2.2 dielectric_loss_tangent=0.0009
  Electrifi: permittivity=1 permeability=0.999991 conductivity=pwl($ds1,Freq)
  PLA: permittivity=2.6 dielectric_loss_tangent=pwl($ds2,Freq)
  copper: permeability=0.999991 conductivity=58000000

design Simulation (HFSS, HFSS Terminal Network, model units mm)
options: open_region{BoundaryType=0 OpFreq=5GHz}
variables:
  Ws = 29mm  # sensitivity 14.5mm..43.5mm
  Lb = 4.5mm  # sensitivity 2.25mm..6.75mm
  R4 = 2.8mm  # sensitivity 1.4mm..4.2mm
  R2 = 3.5mm  # sensitivity 1.75mm..5.25mm
  R3 = 3.25mm  # sensitivity 1.625mm..4.875mm
  R1 = 10mm  # sensitivity 5mm..15mm
  w = 3mm  # sensitivity 1.5mm..4.5mm
  w2 = 4mm  # sensitivity 2mm..6mm
  h = 5mm  # sensitivity 2.5mm..7.5mm
  Lp = 15mm  # sensitivity 7.5mm..22.5mm
  Lg = 14.7mm  # sensitivity 7.35mm..22.05mm
  a = 2mm  # optimise 1mm..3mm; sensitivity 1mm..3mm
  s = 3mm  # optimise 1.5mm..4.5mm; sensitivity 1.5mm..4.5mm
  b = 10mm  # sensitivity 5mm..15mm
  bs = 28.1mm
  Ls = 39mm  # sensitivity 19.5mm..58.5mm
  thickness = 1.2mm  # sensitivity 0.6mm..1.8mm
  thicknessantenna = 0.8mm  # sensitivity 0.4mm..1.2mm
  mm = 3
  e = exp(_t)
geometry:
  EquationCurve2 = equation_curve(x=_t, y=0, z=Lb+sqrt(abs(R3^2-(_t-R3+R1)^2)), _t=-R1 to -R2, segments=100)
  EquationCurve3 = equation_curve(x=_t, y=0, z=-sqrt(R2^2-_t^2), _t=-R2 to R2, segments=100)
  EquationCurve4 = equation_curve(x=_t, y=0, z=Lb+sqrt(abs(R3^2-(_t+R3-R1)^2)), _t=R2 to R1, segments=100)
  EquationCurve5 = equation_curve(x=_t, y=0, z=sqrt(abs(R4^2-_t^2)), _t=-R4 to R4, segments=100)
  ParasiticElement [Electrifi] = equation_curve(x=_t, y=0, z=-sqrt(abs(R4^2-_t^2)), _t=-R4 to R4, segments=100)
  EquationCurve7 = equation_curve(x=_t, y=0, z=-sqrt(abs(R1^2-_t^2)), _t=-R1 to -w/2, segments=100)
  EquationCurve8 = equation_curve(x=_t, y=0, z=-sqrt(R1^2-_t^2), _t=w/2 to R1, segments=100)
  EquationCurve9 = equation_curve(x=_t, y=0, z=-sqrt(abs(R1^2-(w/2)^2)), _t=-w/2 to w/2, segments=100)
  ParasiticElement.unite(EquationCurve5)
  ParasiticElement.cover_lines()
  Polyline1 = polyline((-R1, 0mm, Lb+sqrt(abs(R3^2-(-R1-R3+R1)^2))) (-R1, 0mm, -sqrt(R1^2-(-R1)^2)))
  Polyline2 = polyline((R1, 0mm, Lb+sqrt(abs(R3^2-(-R1-R3+R1)^2))) (R1, 0mm, -sqrt(R1^2-(-R1)^2)))
  Polyline3 = polyline((-R2, 0mm, Lb+sqrt(abs(R3^2-(-R1-R3+R1)^2))) (-R2, 0mm, -sqrt(R1^2-(-R1)^2)))
  Polyline4 = polyline((R2, 0mm, Lb+sqrt(abs(R3^2-(-R1-R3+R1)^2))) (R2, 0mm, -sqrt(R1^2-(-R1)^2)))
  EquationCurve7.unite(EquationCurve9, EquationCurve8, Polyline2, EquationCurve4, Polyline4, EquationCurve3, Polyline3, EquationCurve2, Polyline1)
  EquationCurve7.cover_lines()
  Yshape [Electrifi] = rectangle(corner=(-w2/2, 0mm, -sqrt(abs(R1^2-(w/2)^2))-(Lp)), z_size=h, x_size=w2)
  FeedLine = rectangle(corner=(-w/2, 0mm, -sqrt(abs(R1^2-(w/2)^2))-(Lp-h)), z_size=Lp-h, x_size=w)
  Substrate [PLA] = polyline(z=-sqrt(abs(R1^2-(w/2)^2))-(Lp)-0.2mm, xy: (bs/2, 0mm) (0mm, b) (-bs/2, 0mm), Spline from point 0 over 3)
  Yshape.unite(FeedLine, EquationCurve7)
  [Yshape, ParasiticElement].move(0mm, 20mm, 0mm)
  GroundPlane = rectangle(corner=(-bs/2, 0mm, -sqrt(abs(R1^2-(w/2)^2))-(Lp)), z_size=Lg, x_size=bs)
  Rectangle2 = rectangle(corner=(-s/2, 0mm, -sqrt(abs(R1^2-(w/2)^2))-(Lp)+Lg-a/2), z_size=a, x_size=s)
  GroundPlane.subtract(Rectangle2)
  GroundPlane.move(0mm, -20mm, -0.5mm)
  EquationCurve10 = equation_curve(x=0, y=(-2*exp(40*((_t-0+0.013)))^2)/1000, z=_t, _t=-0.026086 to 10mm)
  Substrate.sweep_along_path(EquationCurve10)
  Substrate.thicken(thickness)
  Polyline5_7 = Substrate.copy()
  EquationCurve11 = equation_curve(x=0, y=(-2*exp(40*((_t-0+0.013)))^2/1000) m, z=_t, _t=-0.025086 to 10mm)
  Polyline5_7_1 = Polyline5_7.copy()
  Polyline5_7_1.delete()
  ParasiticElement.project_sheet(SheetBody=1021 TargetBodies(39364) Thickness=0mm DraftAngle=0deg KeepOriginals)
  Polyline5_7_2 = Polyline5_7.copy()
  Polyline5_7_2.delete()
  GroundPlane.project_sheet(SheetBody=21603 TargetBodies(39791) Thickness=0mm DraftAngle=0deg KeepOriginals)
  Polyline5_7_3 = Polyline5_7.copy()
  [Polyline5_7, Polyline5_7_3].delete()
  Yshape.project_sheet(SheetBody=2260 TargetBodies(39838) Thickness=0mm DraftAngle=0deg KeepOriginals)
  [Yshape, ParasiticElement].thicken(thicknessantenna)
  coordinate_system RelativeCS1 = origin=(0mm, 11.7mm, -24.8mm) x=(1mm, 0mm, 0mm) y=(0mm, 1mm, 0mm)
  coordinate_system RelativeCS2 = origin=(0mm, 0mm, 0.15mm) x=(1mm, 0mm, 0mm) y=(0mm, 1mm, 0mm) in RelativeCS1
  Yshape.split(plane=XY, keep=PositiveOnly) in RelativeCS2
  Port [pec] = object_from(Yshape.face(at (0, 11.4764, -24.65)))
  Port.sweep_along_vector((0mm, 0mm, -0.8mm)) in RelativeCS2
  Polyline5_8 = Substrate.copy()
  Port.subtract(Polyline5_8)
  coordinate_system RelativeCS3 = origin=(0mm, 0mm, -0.3mm) x=(1mm, 0mm, 0mm) y=(0mm, 1mm, 0mm) in RelativeCS2
  Port.split(plane=XY, keep=PositiveOnly) in RelativeCS3
  Port_1 [copper] = object_from(Port.edge(at (-0.000348782, 11.9778, -24.95)))
  Port_1.sweep_along_vector((0mm, -3mm, 0mm)) in RelativeCS3
  Rectangle1_ObjectFromFace3 = object_from(GroundPlane.face(at (0, 9.41868, -17.6113)))
  Rectangle1_ObjectFromFace3.thicken(3mm)
  Port_1.subtract(Rectangle1_ObjectFromFace3)
  point Point1 = (0mm, -3.5338301mm, 39.95mm) in RelativeCS3
  coordinate_system RelativeCS4 = origin=(0mm, 4mm, 8mm) x=(1mm, 0mm, 0mm) y=(0mm, 1mm, 0mm) in RelativeCS3
  RadiatingSurface [vacuum] = region(absolute_offset=20mm on all sides)
boundaries and excitations:
  GroundPlane: Perfect E Objects=GroundPlane
  AutoOpen1: Radiation Objects=RadiatingSurface
  Port: Terminal port=1 Faces=Port.face(at (0, 11.4666, -24.95)) TerminalResistance=50ohm
  1: Lumped Port Faces=Port_1.face(at (0.00828338, 10.9419, -24.95)) LumpedPortType=Terminal Impedance=50ohm
  reference conductors: GroundPlane
mesh:
  initial mesh: GlobalCurvilinear{Apply} GlobalModelRes{DefeatureLength=0.02mm}
setups:
  Auto1: HfssDriven Frequency=5GHz MaxDeltaS=0.02 MaximumPasses=6 MinimumPasses=1 MinimumConvergedPasses=1 PercentRefinement=30 BasisOrder=1 PortAccuracy=2 DrivenSolverType="Direct Solver"
    sweep Sweep: 1GHz to 16GHz, 401 points; Type=Interpolating InterpTolerance=0.5 InterpMaxSolns=250 PassivityErrorTolerance=0.0001
source amplitudes:
  1:1: 1V 0deg
radiation setups:
  3D: Infinite Sphere Theta=0deg..180deg step 2deg Phi=-180deg..180deg step 2deg
  Elevation: Infinite Sphere Theta=-180deg..180deg step 1deg Phi=0deg..90deg step 90deg
  Azimuth: Infinite Sphere Theta=90deg..90deg step 0deg Phi=-180deg..180deg step 1deg
reports:
  Terminal S Parameter Plot1: dB(St(Port,Port)) vs Freq on Auto1 : Sweep
